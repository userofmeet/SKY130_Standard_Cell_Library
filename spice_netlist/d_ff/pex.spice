* NGSPICE file created from d_ff.ext - technology: sky130A

.subckt d_ff DIN CLK Q VDD VSS
X0 a_850_n252# a_90_n458# a_1794_n458# VDD sky130_fd_pr__pfet_01v8 ad=0.378 pd=3.12 as=0.378 ps=3.12 w=1.26 l=0.15
**devattr s=15120,624 d=15120,624
X1 a_3383_n458# a_2758_n252# VDD VDD sky130_fd_pr__pfet_01v8 ad=0.378 pd=3.12 as=0.378 ps=3.12 w=1.26 l=0.15
**devattr s=15120,624 d=15120,624
X2 a_530_n458# DIN VSS VSS sky130_fd_pr__nfet_01v8 ad=0.126 pd=1.44 as=0.126 ps=1.44 w=0.42 l=0.15
**devattr s=5040,288 d=5040,288
X3 a_850_n252# CLK a_1794_n458# VSS sky130_fd_pr__nfet_01v8 ad=0.126 pd=1.44 as=0.126 ps=1.44 w=0.42 l=0.15
**devattr s=5040,288 d=5040,288
X4 a_3699_n458# a_3383_n458# VSS VSS sky130_fd_pr__nfet_01v8 ad=0.126 pd=1.44 as=0.126 ps=1.44 w=0.42 l=0.15
**devattr s=5040,288 d=5040,288
X5 a_850_n252# CLK a_530_n458# VDD sky130_fd_pr__pfet_01v8 ad=0.378 pd=3.12 as=0.378 ps=3.12 w=1.26 l=0.15
**devattr s=15120,624 d=15120,624
X6 a_2758_n252# CLK a_3699_n458# VDD sky130_fd_pr__pfet_01v8 ad=0.378 pd=3.12 as=0.378 ps=3.12 w=1.26 l=0.15
**devattr s=15120,624 d=15120,624
X7 a_90_n458# CLK VSS VSS sky130_fd_pr__nfet_01v8 ad=0.126 pd=1.44 as=0.126 ps=1.44 w=0.42 l=0.15
**devattr s=5040,288 d=5040,288
X8 a_850_n252# a_90_n458# a_530_n458# VSS sky130_fd_pr__nfet_01v8 ad=0.126 pd=1.44 as=0.126 ps=1.44 w=0.42 l=0.15
**devattr s=5040,288 d=5040,288
X9 a_1477_n458# a_850_n252# VDD VDD sky130_fd_pr__pfet_01v8 ad=0.378 pd=3.12 as=0.378 ps=3.12 w=1.26 l=0.15
**devattr s=15120,624 d=15120,624
X10 Q a_3383_n458# VDD VDD sky130_fd_pr__pfet_01v8 ad=0.378 pd=3.12 as=0.378 ps=3.12 w=1.26 l=0.15
**devattr s=15120,624 d=15120,624
X11 a_1794_n458# a_1477_n458# VSS VSS sky130_fd_pr__nfet_01v8 ad=0.126 pd=1.44 as=0.126 ps=1.44 w=0.42 l=0.15
**devattr s=5040,288 d=5040,288
X12 a_530_n458# DIN VDD VDD sky130_fd_pr__pfet_01v8 ad=0.378 pd=3.12 as=0.378 ps=3.12 w=1.26 l=0.15
**devattr s=15120,624 d=15120,624
X13 a_3699_n458# a_3383_n458# VDD VDD sky130_fd_pr__pfet_01v8 ad=0.378 pd=3.12 as=0.378 ps=3.12 w=1.26 l=0.15
**devattr s=15120,624 d=15120,624
X14 a_90_n458# CLK VDD VDD sky130_fd_pr__pfet_01v8 ad=0.378 pd=3.12 as=0.378 ps=3.12 w=1.26 l=0.15
**devattr s=15120,624 d=15120,624
X15 a_2758_n252# a_90_n458# a_3699_n458# VSS sky130_fd_pr__nfet_01v8 ad=0.126 pd=1.44 as=0.126 ps=1.44 w=0.42 l=0.15
**devattr s=5040,288 d=5040,288
X16 a_3383_n458# a_2758_n252# VSS VSS sky130_fd_pr__nfet_01v8 ad=0.126 pd=1.44 as=0.126 ps=1.44 w=0.42 l=0.15
**devattr s=5040,288 d=5040,288
X17 a_1794_n458# a_1477_n458# VDD VDD sky130_fd_pr__pfet_01v8 ad=0.378 pd=3.12 as=0.378 ps=3.12 w=1.26 l=0.15
**devattr s=15120,624 d=15120,624
X18 a_2758_n252# a_90_n458# a_1477_n458# VDD sky130_fd_pr__pfet_01v8 ad=0.378 pd=3.12 as=0.378 ps=3.12 w=1.26 l=0.15
**devattr s=15120,624 d=15120,624
X19 a_1477_n458# a_850_n252# VSS VSS sky130_fd_pr__nfet_01v8 ad=0.126 pd=1.44 as=0.126 ps=1.44 w=0.42 l=0.15
**devattr s=5040,288 d=5040,288
X20 a_2758_n252# CLK a_1477_n458# VSS sky130_fd_pr__nfet_01v8 ad=0.126 pd=1.44 as=0.126 ps=1.44 w=0.42 l=0.15
**devattr s=5040,288 d=5040,288
X21 Q a_3383_n458# VSS VSS sky130_fd_pr__nfet_01v8 ad=0.126 pd=1.44 as=0.126 ps=1.44 w=0.42 l=0.15
**devattr s=5040,288 d=5040,288
C0 a_3383_n458# a_90_n458# 0.1308f
C1 a_850_n252# a_90_n458# 0.43854f
C2 a_2758_n252# a_1477_n458# 0.1661f
C3 a_3699_n458# VDD 0.30288f
C4 a_530_n458# VDD 0.31251f
C5 a_1477_n458# DIN 0
C6 VDD CLK 0.57944f
C7 a_850_n252# a_3383_n458# 0
C8 a_2758_n252# a_3699_n458# 0.17965f
C9 Q VDD 0.109f
C10 DIN a_530_n458# 0.03371f
C11 a_1794_n458# VDD 0.30287f
C12 a_2758_n252# CLK 0.2599f
C13 a_2758_n252# Q 0.0041f
C14 a_90_n458# VDD 0.9633f
C15 DIN CLK 0.03727f
C16 a_2758_n252# a_1794_n458# 0
C17 a_2758_n252# a_90_n458# 0.26558f
C18 DIN a_90_n458# 0.05421f
C19 a_3383_n458# VDD 0.42977f
C20 a_850_n252# VDD 0.80176f
C21 a_2758_n252# a_3383_n458# 0.31764f
C22 a_2758_n252# a_850_n252# 0.00375f
C23 a_850_n252# DIN 0
C24 a_2758_n252# VDD 0.80137f
C25 DIN VDD 0.12129f
C26 a_3699_n458# a_1477_n458# 0
C27 a_1477_n458# a_530_n458# 0
C28 a_1477_n458# CLK 0.29893f
C29 a_1477_n458# a_1794_n458# 0.11287f
C30 a_3699_n458# CLK 0.11496f
C31 a_530_n458# CLK 0.15862f
C32 a_1477_n458# a_90_n458# 0.20192f
C33 Q CLK 0
C34 a_3699_n458# a_90_n458# 0.02264f
C35 a_530_n458# a_90_n458# 0.05305f
C36 a_1794_n458# CLK 0.02017f
C37 a_1477_n458# a_3383_n458# 0.00326f
C38 a_850_n252# a_1477_n458# 0.32068f
C39 a_90_n458# CLK 1.22358f
C40 Q a_90_n458# 0.00351f
C41 a_3699_n458# a_3383_n458# 0.11421f
C42 a_3699_n458# a_850_n252# 0
C43 a_850_n252# a_530_n458# 0.16478f
C44 a_1794_n458# a_90_n458# 0.12378f
C45 a_3383_n458# CLK 0.15686f
C46 a_850_n252# CLK 0.09829f
C47 Q a_3383_n458# 0.03511f
C48 a_3383_n458# a_1794_n458# 0
C49 a_850_n252# a_1794_n458# 0.17916f
C50 a_1477_n458# VDD 0.45992f
C51 Q VSS 0.13663f
C52 a_3699_n458# VSS 0.91011f
C53 a_1794_n458# VSS 3.34591f
C54 a_530_n458# VSS 0.35989f
C55 VDD VSS 8.38546f
.ends
