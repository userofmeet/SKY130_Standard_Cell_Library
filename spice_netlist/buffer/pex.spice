* NGSPICE file created from project1_bufferckt.ext - technology: sky130A

.subckt project1_bufferckt vdd vss int in out
X0 vss in int vss sky130_fd_pr__nfet_01v8 ad=0.0798 pd=0.8 as=0.1596 ps=1.6 w=0.42 l=0.15
**devattr s=6384,320 d=3192,160
X1 vdd in int vdd sky130_fd_pr__pfet_01v8 ad=0.2337 pd=1.61 as=0.4674 ps=3.22 w=1.23 l=0.15
**devattr s=18696,644 d=9348,322
X2 out int vss vss sky130_fd_pr__nfet_01v8 ad=0.2394 pd=1.98 as=0.0798 ps=0.8 w=0.42 l=0.15
**devattr s=3192,160 d=9576,396
X3 out int vdd vdd sky130_fd_pr__pfet_01v8 ad=0.6396 pd=3.5 as=0.2337 ps=1.61 w=1.23 l=0.15
**devattr s=9348,322 d=25584,700
C0 in vdd 0.0671f
C1 out vdd 0.06999f
C2 out in 0.0041f
C3 int vdd 0.11573f
C4 in int 0.14349f
C5 out int 0.08094f
C6 out vss 0.37429f
C7 vdd vss 0.76028f
.ends
