.lib /foss/pdks/sky130A/libs.tech/ngspice/sky130.lib.spice tt

.param slew=10p
.param Cload=0.5f

.subckt project1_nand vdd A vss B out A_b
X0 out A_b a_1488_n84# vss sky130_fd_pr__nfet_01v8 ad=0.0798 pd=0.8 as=0.1428 ps=1.31 w=0.42 l=0.15
**devattr s=6384,320 d=3192,160
X1 out A_b vdd vdd sky130_fd_pr__pfet_01v8 ad=0.4674 pd=3.22 as=0.4674 ps=3.22 w=1.23 l=0.15
**devattr s=18696,644 d=18696,644
X2 a_1488_n84# B vss vss sky130_fd_pr__nfet_01v8 ad=0.1428 pd=1.31 as=0.1064 ps=1.06667 w=0.42 l=0.15
**devattr s=3192,160 d=6384,320
X3 A_b A vss vss sky130_fd_pr__nfet_01v8 ad=0.1596 pd=1.6 as=0.1064 ps=1.06667 w=0.42 l=0.15
**devattr s=6384,320 d=6384,320
X4 A_b A vdd vdd sky130_fd_pr__pfet_01v8 ad=0.4674 pd=3.22 as=0.4674 ps=3.22 w=1.23 l=0.15
**devattr s=18696,644 d=18696,644
X5 vss B a_1488_n84# vss sky130_fd_pr__nfet_01v8 ad=0.1064 pd=1.06667 as=0.1428 ps=1.31 w=0.42 l=0.15
**devattr s=5040,204 d=3192,160
X6 vdd B out vdd sky130_fd_pr__pfet_01v8 ad=0.4674 pd=3.22 as=0.4674 ps=3.22 w=1.23 l=0.15
**devattr s=18696,644 d=18696,644
X7 a_1488_n84# A_b out vss sky130_fd_pr__nfet_01v8 ad=0.1428 pd=1.31 as=0.0798 ps=0.8 w=0.42 l=0.15
**devattr s=3192,160 d=5040,204
C0 out B 0.03874f
C1 a_1488_n84# vdd 0.06288f
C2 vdd A 0.08741f
C3 out vdd 0.19544f
C4 a_1488_n84# A 0.00138f
C5 out a_1488_n84# 0.08702f
C6 out A 0
C7 A_b B 0.0249f
C8 vdd A_b 0.18193f
C9 a_1488_n84# A_b 0.08276f
C10 vdd B 0.09653f
C11 A_b A 0.06117f
C12 out A_b 0.09783f
C13 a_1488_n84# B 0.05385f
C14 out vss 0.24557f
C15 vdd vss 1.27392f
C16 a_1488_n84# vss 0.81643f
.ends

Vdd vdd 0 1.8

VA A 0 0
VB B 0 PULSE(0 1.8 1n 100p 100p 2n 4n)

Xnand vdd A 0 B out A_b project1_nand

.control

tran 1p 8n

plot I(VB)

meas tran Qrise integ I(VB) from=1n to=1.16n
meas tran Qfall integ I(VB) from=3.1n to=3.32n

let Crise=abs(Qrise)/1.8
let Cfall=abs(Qfall)/1.8
let Cavg=(Crise+Cfall)/2

let Crise_pF=Crise/1e-12
let Cfall_pF=Cfall/1e-12
let Cavg_pF=Cavg/1e-12

echo ""
echo "========================================"
echo "       NAND INPUT CAPACITANCE"
echo "       A = 0 V, B = VARYING"
echo "========================================"

echo ""
echo "Rise Charge (C):"
print Qrise

echo ""
echo "Fall Charge (C):"
print Qfall

echo ""
echo "Rise Capacitance (pF):"
print Crise_pF

echo ""
echo "Fall Capacitance (pF):"
print Cfall_pF

echo ""
echo "Average Capacitance (pF):"
print Cavg_pF

echo ""
echo "========================================"

.endc
