.lib /foss/pdks/sky130A/libs.tech/ngspice/sky130.lib.spice tt

.param slew=10p
.param Cload=0.5f

.subckt project1_nand vdd A vss B out A_b
X0 out A_b a_1488_n84# vss sky130_fd_pr__nfet_01v8 ad=0.0798 pd=0.8 as=0.1428 ps=1.31 w=0.42 l=0.15
**devattr s=6384,320 d=3192,160
X1 out A_b vdd vdd sky130_fd_pr__pfet_01v8 ad=0.4674 pd=3.22 as=0.4674 ps=3.22 w=1.23 l=0.15
**devattr s=18696,644 d=18696,644
X2 a_1488_n84# B vss vss sky130_fd_pr__nfet_01v8 ad=0.1428 pd=1.31 as=0.1064 ps=1.06667 w=0.42 l=0.15
**devattr s=3192,160 d=6384,320
X3 A_b A vss vss sky130_fd_pr__nfet_01v8 ad=0.1596 pd=1.6 as=0.1064 ps=1.06667 w=0.42 l=0.15
**devattr s=6384,320 d=6384,320
X4 A_b A vdd vdd sky130_fd_pr__pfet_01v8 ad=0.4674 pd=3.22 as=0.4674 ps=3.22 w=1.23 l=0.15
**devattr s=18696,644 d=18696,644
X5 vss B a_1488_n84# vss sky130_fd_pr__nfet_01v8 ad=0.1064 pd=1.06667 as=0.1428 ps=1.31 w=0.42 l=0.15
**devattr s=5040,204 d=3192,160
X6 vdd B out vdd sky130_fd_pr__pfet_01v8 ad=0.4674 pd=3.22 as=0.4674 ps=3.22 w=1.23 l=0.15
**devattr s=18696,644 d=18696,644
X7 a_1488_n84# A_b out vss sky130_fd_pr__nfet_01v8 ad=0.1428 pd=1.31 as=0.0798 ps=0.8 w=0.42 l=0.15
**devattr s=3192,160 d=5040,204
C0 out B 0.03874f
C1 a_1488_n84# vdd 0.06288f
C2 vdd A 0.08741f
C3 out vdd 0.19544f
C4 a_1488_n84# A 0.00138f
C5 out a_1488_n84# 0.08702f
C6 out A 0
C7 A_b B 0.0249f
C8 vdd A_b 0.18193f
C9 a_1488_n84# A_b 0.08276f
C10 vdd B 0.09653f
C11 A_b A 0.06117f
C12 out A_b 0.09783f
C13 a_1488_n84# B 0.05385f
C14 out vss 0.24557f
C15 vdd vss 1.27392f
C16 a_1488_n84# vss 0.81643f
.ends

Vdd vdd 0 1.8
VA A 0 0
VB B 0 PULSE(1.8 0 1n {slew} {slew} 2n 4n)

Xnand vdd A 0 B out A_b project1_nand

Cload out 0 {Cload}

.control

alterparam slew=10p
alterparam Cload=0.5f
reset
tran 1p 8n
meas tran tplh1 trig V(A) val=0.9 fall=1 targ V(out) val=0.9 rise=1
meas tran tphl1 trig V(A) val=0.9 rise=1 targ V(out) val=0.9 fall=1
echo "========================================"
echo "CASE 1: Slew=10ps, Cload=0.5fF"
echo "Propagation delay A -> OUT"
echo "tPLH:"
print tplh1
echo "tPHL:"
print tphl1

alterparam slew=10p
alterparam Cload=10f
reset
tran 1p 8n
meas tran tplh2 trig V(A) val=0.9 fall=1 targ V(out) val=0.9 rise=1
meas tran tphl2 trig V(A) val=0.9 rise=1 targ V(out) val=0.9 fall=1
echo "========================================"
echo "CASE 2: Slew=10ps, Cload=10fF"
echo "Propagation delay A -> OUT"
echo "tPLH:"
print tplh2
echo "tPHL:"
print tphl2

alterparam slew=10p
alterparam Cload=100f
reset
tran 1p 8n
meas tran tplh3 trig V(A) val=0.9 fall=1 targ V(out) val=0.9 rise=1
meas tran tphl3 trig V(A) val=0.9 rise=1 targ V(out) val=0.9 fall=1
echo "========================================"
echo "CASE 3: Slew=10ps, Cload=100fF"
echo "Propagation delay A -> OUT"
echo "tPLH:"
print tplh3
echo "tPHL:"
print tphl3

alterparam slew=100p
alterparam Cload=0.5f
reset
tran 1p 8n
meas tran tplh4 trig V(A) val=0.9 fall=1 targ V(out) val=0.9 rise=1
meas tran tphl4 trig V(A) val=0.9 rise=1 targ V(out) val=0.9 fall=1
echo "========================================"
echo "CASE 4: Slew=100ps, Cload=0.5fF"
echo "Propagation delay A -> OUT"
echo "tPLH:"
print tplh4
echo "tPHL:"
print tphl4

alterparam slew=100p
alterparam Cload=10f
reset
tran 1p 8n
meas tran tplh5 trig V(A) val=0.9 fall=1 targ V(out) val=0.9 rise=1
meas tran tphl5 trig V(A) val=0.9 rise=1 targ V(out) val=0.9 fall=1
echo "========================================"
echo "CASE 5: Slew=100ps, Cload=10fF"
echo "Propagation delay A -> OUT"
echo "tPLH:"
print tplh5
echo "tPHL:"
print tphl5

alterparam slew=100p
alterparam Cload=100f
reset
tran 1p 8n
meas tran tplh6 trig V(A) val=0.9 fall=1 targ V(out) val=0.9 rise=1
meas tran tphl6 trig V(A) val=0.9 rise=1 targ V(out) val=0.9 fall=1
echo "========================================"
echo "CASE 6: Slew=100ps, Cload=100fF"
echo "Propagation delay A -> OUT"
echo "tPLH:"
print tplh6
echo "tPHL:"
print tphl6

alterparam slew=1000p
alterparam Cload=0.5f
reset
tran 1p 12n
meas tran tplh7 trig V(A) val=0.9 fall=1 targ V(out) val=0.9 rise=1
meas tran tphl7 trig V(A) val=0.9 rise=1 targ V(out) val=0.9 fall=1
echo "========================================"
echo "CASE 7: Slew=1000ps, Cload=0.5fF"
echo "Propagation delay A -> OUT"
echo "tPLH:"
print tplh7
echo "tPHL:"
print tphl7

alterparam slew=1000p
alterparam Cload=10f
reset
tran 1p 12n
meas tran tplh8 trig V(A) val=0.9 fall=1 targ V(out) val=0.9 rise=1
meas tran tphl8 trig V(A) val=0.9 rise=1 targ V(out) val=0.9 fall=1
echo "========================================"
echo "CASE 8: Slew=1000ps, Cload=10fF"
echo "Propagation delay A -> OUT"
echo "tPLH:"
print tplh8
echo "tPHL:"
print tphl8

alterparam slew=1000p
alterparam Cload=100f
reset
tran 1p 25n
meas tran tplh9 trig V(A) val=0.9 fall=1 targ V(out) val=0.9 rise=1
meas tran tphl9 trig V(A) val=0.9 rise=1 targ V(out) val=0.9 fall=1
echo "========================================"
echo "CASE 9: Slew=1000ps, Cload=100fF"
echo "Propagation delay A -> OUT"
echo "tPLH:"
print tplh9
echo "tPHL:"
print tphl9

echo "========================================"
echo "ALL 9 CASES COMPLETE"
echo "========================================"

.endc
