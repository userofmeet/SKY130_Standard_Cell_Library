*========================================================
* DFF PEX - CLK -> Q RISE DELAY
*========================================================

.lib /usr/local/share/pdk/sky130A/libs.tech/ngspice/sky130.lib.spice tt

.include dff_pex.spice

.param CL=0.05f
.param DS=1000p

*--------------------------------------------------------
* Supplies
*--------------------------------------------------------
VDD vdd 0 1.8
VSS vss 0 0

*--------------------------------------------------------
* Data input
*
* D=0 initially
* D rises well before the second clock edge
*--------------------------------------------------------
VDIN DIN 0 PULSE(0 1.8 8n {DS} {DS} 20n 40n)

*--------------------------------------------------------
* Clock
*
* Rising edges:
*   5 ns   -> initialize flop
*   15 ns  -> measurement edge
*--------------------------------------------------------
VCLK CLK 0 PULSE(0 1.8 5n 10p 10p 5n 10n)

*--------------------------------------------------------
* DUT
*--------------------------------------------------------
XDFF DIN CLK Q vdd vss d_ff

*--------------------------------------------------------
* Load
*--------------------------------------------------------
CLOAD Q 0 {CL}

*--------------------------------------------------------
* Simulation
*--------------------------------------------------------
.tran 1p 25n

.control

run

plot V(DIN) V(CLK) V(Q)

*--------------------------------------------------------
* Measure CLK->Q rise delay
*
* Measure at second rising clock edge
*--------------------------------------------------------

meas tran tCLK TRIG V(CLK) VAL=0.9 RISE=2

meas tran tQ TARG V(Q) VAL=0.9 RISE=1

let Tclkq_rise = tQ - tCLK

echo "--------------------------------"
print tCLK
print tQ
print Tclkq_rise
echo "--------------------------------"

.endc

.end
