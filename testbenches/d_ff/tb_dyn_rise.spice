*========================================================
* DFF PEX - DYNAMIC RISE POWER
*
* CL = output capacitance
* DS = D/input slew
*
* CLK slew = fixed at 10 ps
* CLK period = 10 ns
*
* Power is calculated over ONE COMPLETE CLOCK CYCLE
*
* Pavg = Ecycle / Tclk
*========================================================

.lib /foss/pdks/sky130A/libs.tech/ngspice/sky130.lib.spice tt

.include dff_pex.spice

*--------------------------------------------------------
* PARAMETERS
*--------------------------------------------------------

.param CL=100f
.param DS=1000p

*--------------------------------------------------------
* SUPPLY
*--------------------------------------------------------

VDD vdd 0 1.8
VSS vss 0 0

*--------------------------------------------------------
* D INPUT
*
* D starts rising before the target CLK edge.
*
* D 50% crossing is kept fixed at 5 ns.
*
* For different DS values:
*
* DS = 10 ps:
*       start = 4.995 ns
*
* DS = 100 ps:
*       start = 4.950 ns
*
* DS = 1000 ps:
*       start = 4.500 ns
*
* D remains HIGH during the measured clock cycle.
*--------------------------------------------------------

VDIN DIN 0 PULSE(0 1.8 {5n-DS/2} {DS} {DS} 15n 20n)

*--------------------------------------------------------
* CLOCK
*
* Rising edges:
*   2 ns  -> initialization
*   12 ns -> target edge, Q rises
*   22 ns -> next edge
*
* Clock period = 10 ns
* Clock slew = 10 ps
*--------------------------------------------------------

VCLK CLK 0 PULSE(0 1.8 2n 10p 10p 3n 10n)

*--------------------------------------------------------
* DFF
*--------------------------------------------------------

XDFF DIN CLK Q vdd vss d_ff

*--------------------------------------------------------
* OUTPUT LOAD
*--------------------------------------------------------

CLOAD Q 0 {CL}

*--------------------------------------------------------
* TRANSIENT SIMULATION
*--------------------------------------------------------

.tran 1p 23n

.control

run

*--------------------------------------------------------
* PLOT
*--------------------------------------------------------

plot V(DIN) V(CLK) V(Q)

*--------------------------------------------------------
* SUPPLY POWER
*--------------------------------------------------------

let psupply = 1.8*abs(i(VDD))

*--------------------------------------------------------
* ENERGY OVER ONE COMPLETE CLOCK CYCLE
*
* Target cycle:
*
*       12 ns ---------------- 22 ns
*
* Clock period = 10 ns
*--------------------------------------------------------

meas tran Ecycle integ psupply from=12n to=22n

*--------------------------------------------------------
* AVERAGE POWER
*--------------------------------------------------------

let Prise = Ecycle/10n

*--------------------------------------------------------
* PRINT RESULTS
*--------------------------------------------------------

print Ecycle
print Prise

.endc

.end
